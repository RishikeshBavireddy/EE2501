BJT Small signal analysis

.include bc547.mod

Vcc n1 0 DC 6
* Vbb n2 0 DC 3 AC .1
Vbb n2 0 SIN(3 .1 100)

Rc n1 Vc 470
Rb n2 Vb 47000
Q1 Vc Vb 0 BC547

* .ac dec 10 100 10Meg
* .control
* run
*
* print mag(@q1[ic])
* print @q1[ib]
*
* plot v(Vc)
* * plot (v(n1) - v(Vc))/470
* * plot (v(n2) - v(Vb))/47000
* * plot ((v(n1) - v(Vc))/470) / ((v(n2) - v(Vb))/47000)
*
* wrdata beta_vs_freq.dat ((v(n1)-v(Vc))/470) / ((v(n2)-v(Vb))/47000)
*
* .endc
* .end

.tran 1ms 500ms
.control
run

* print @q1[ic]
* print @q1[ib]
plot v(Vc)
wrdata test.dat (v(n1) - v(Vc))/470
.endc
.end
