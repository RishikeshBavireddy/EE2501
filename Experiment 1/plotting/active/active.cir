*Netlist
Vcc vcc 0 5
Vee vee 0 -5
Vin in 0 AC 1
C1 in 1 15p
R1 1 out 1Meg
C2 1 2 15p
R2 2 0 1Meg
XU1 2 out vcc vee out LM358/NS
.include LM358.mod

.control
AC DEC 30 10 1meg
set wr_singlescale
wrdata active.dat 20*log10(abs(v(out)/v(in))) phase(v(out))
.endc
.end
