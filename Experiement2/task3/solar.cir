*Netlist

V1 in 0 DC 1
R1 in p 4700
D1 p 0 DI_1N4007
.include 1N4007.mod

.control
dc V1 0.1 0.8 0.2
set wr_singlescale
wrdata forward.dat v(p)
.endc

.end
